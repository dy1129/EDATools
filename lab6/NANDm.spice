* NGSPICE file created from NANDm.ext - technology: scmos

.subckt NANDm vdd A B C vss
M1000 vdd B C vdd pfet w=6u l=0.6u
+  ad=12.6p pd=16.2u as=7.2p ps=8.4u
M1001 a_148_64# A vss vss nfet w=6u l=0.6u
+  ad=2.7p pd=6.9u as=12.6p ps=16.2u
M1002 C A vdd vdd pfet w=6u l=0.6u
+  ad=7.2p pd=8.4u as=12.6p ps=16.2u
M1003 C B a_148_64# vss nfet w=6u l=0.6u
+  ad=12.6p pd=16.2u as=2.7p ps=6.9u
.ends
