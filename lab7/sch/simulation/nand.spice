** sch_path: /home/dayesong/ETRI050_DesignKit/lab7/sch/nand.sch
.subckt nand A B Y vdd gnd
*.ipin A
*.ipin B
*.opin Y
*.iopin vdd
*.iopin gnd
M3 net1 A gnd gnd nfet w=6u l=0.6u m=1
M4 Y B vdd vdd pfet w=6u l=0.6u m=1
M2 Y A vdd vdd pfet w=6u l=0.6u m=1
M1 Y B net1 gnd nfet w=6u l=0.6u m=1
.ends
.end
