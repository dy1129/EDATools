** sch_path: /home/dayesong/ETRI050_DesignKit/lab7/sch/untitled.sch
**.subckt untitled
x1 VDD GND A B Y XNOR
vA A GND pulse(0 5 1u 1u 1u 20u 40u)
vB B GND pulse(0 5 1u 1u 1u 40u 80u)
vdd VDD GND 5
**** begin user architecture code

.include ~/ETRI050_DesignKit/tech/05cmos_model_240201.lib
.save all
.tran 5u 200u

**** end user architecture code
**.ends

* expanding   symbol:  /home/dayesong/ETRI050_DesignKit/lab7/sch/XNOR.sym # of pins=6
** sym_path: /home/dayesong/ETRI050_DesignKit/lab7/sch/XNOR.sym
** sch_path: /home/dayesong/ETRI050_DesignKit/lab7/sch/XNOR.sch
.subckt XNOR vdd gnd A B Y
*.ipin A
*.ipin B
*.opin Y
*.iopin vdd
*.iopin gnd
x1 A B net3 vdd gnd nand
x2 net3 net4 net1 vdd gnd nand
x4 A B net2 vdd gnd nor
x5 net1 net5 vdd gnd inv
x3 net2 net4 vdd gnd inv
x6 net5 Y vdd gnd inv
.ends

* expanding   symbol:  /home/dayesong/ETRI050_DesignKit/lab7/sch/nand.sym # of pins=5
** sym_path: /home/dayesong/ETRI050_DesignKit/lab7/sch/nand.sym
** sch_path: /home/dayesong/ETRI050_DesignKit/lab7/sch/nand.sch
.subckt nand A B Y vdd gnd
*.ipin A
*.ipin B
*.opin Y
*.iopin vdd
*.iopin gnd
M3 net1 A gnd gnd nfet w=6u l=0.6u m=1
M4 Y B vdd vdd pfet w=6u l=0.6u m=1
M2 Y A vdd vdd pfet w=6u l=0.6u m=1
M1 Y B net1 gnd nfet w=6u l=0.6u m=1
.ends

* expanding   symbol:  /home/dayesong/ETRI050_DesignKit/lab7/sch/nor.sym # of pins=5
** sym_path: /home/dayesong/ETRI050_DesignKit/lab7/sch/nor.sym
** sch_path: /home/dayesong/ETRI050_DesignKit/lab7/sch/nor.sch
.subckt nor A B Y vdd gnd
*.ipin A
*.ipin B
*.opin Y
*.iopin vdd
*.iopin gnd
M3 net1 A vdd vdd pfet w=12u l=0.6u m=1
M4 Y A gnd gnd nfet w=3u l=0.6u m=1
M1 Y B gnd gnd nfet w=3u l=0.6u m=1
M2 Y B net1 vdd pfet w=12u l=0.6u m=1
.ends

* expanding   symbol:  /home/dayesong/ETRI050_DesignKit/lab7/sch/inv.sym # of pins=4
** sym_path: /home/dayesong/ETRI050_DesignKit/lab7/sch/inv.sym
** sch_path: /home/dayesong/ETRI050_DesignKit/lab7/sch/inv.sch
.subckt inv A Y vdd gnd
*.ipin A
*.opin Y
*.iopin vdd
*.iopin gnd
M1 Y A vdd vdd pfet w=6u l=0.6u m=1
M2 Y A gnd gnd nfet w=3u l=0.6u m=1
.ends

.GLOBAL VDD
.GLOBAL GND
.end
