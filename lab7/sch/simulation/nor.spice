** sch_path: /home/dayesong/ETRI050_DesignKit/lab7/sch/nor.sch
.subckt nor A B Y vdd gnd
*.ipin A
*.ipin B
*.opin Y
*.iopin vdd
*.iopin gnd
M3 net1 A vdd vdd pfet w=12u l=0.6u m=1
M4 Y A gnd gnd nfet w=3u l=0.6u m=1
M1 Y B gnd gnd nfet w=3u l=0.6u m=1
M2 Y B net1 vdd pfet w=12u l=0.6u m=1
.ends
.end
