** sch_path: /home/dayesong/ETRI050_DesignKit/lab7/sch/XORx.sch
.subckt XORx vdd gnd A B Y
*.ipin A
*.ipin B
*.opin Y
*.iopin vdd
*.iopin gnd
x4 vdd A net1 B gnd NORx
x2 vdd net1 net4 gnd INVx
x3 vdd net3 net2 net4 gnd NANDx
x5 vdd net2 Y gnd INVx
x1 vdd A net3 B gnd NANDx
.ends

* expanding   symbol:  /home/dayesong/ETRI050_DesignKit/lab7/sch/NORx.sym # of pins=5
** sym_path: /home/dayesong/ETRI050_DesignKit/lab7/sch/NORx.sym
** sch_path: /home/dayesong/ETRI050_DesignKit/lab7/sch/NORx.sch
.subckt NORx vdd A Y B gnd
*.ipin A
*.ipin B
*.opin Y
*.iopin vdd
*.iopin gnd
M1 net1 A vdd vdd pfet w=12u l=0.6u m=1
M2 Y B net1 vdd pfet w=12u l=0.6u m=1
M3 Y B gnd gnd nfet w=3u l=0.6u m=1
M4 Y A gnd gnd nfet w=3u l=0.6u m=1
.ends

* expanding   symbol:  /home/dayesong/ETRI050_DesignKit/lab7/sch/INVx.sym # of pins=4
** sym_path: /home/dayesong/ETRI050_DesignKit/lab7/sch/INVx.sym
** sch_path: /home/dayesong/ETRI050_DesignKit/lab7/sch/INVx.sch
.subckt INVx vdd A Y gnd
*.ipin A
*.opin Y
*.iopin vdd
*.iopin gnd
M1 Y A vdd vdd pfet w=6u l=0.6u m=1
M2 Y A gnd gnd nfet w=3u l=0.6u m=1
.ends

* expanding   symbol:  /home/dayesong/ETRI050_DesignKit/lab7/sch/NANDx.sym # of pins=5
** sym_path: /home/dayesong/ETRI050_DesignKit/lab7/sch/NANDx.sym
** sch_path: /home/dayesong/ETRI050_DesignKit/lab7/sch/NANDx.sch
.subckt NANDx vdd A Y B gnd
*.ipin A
*.ipin B
*.opin Y
*.iopin vdd
*.iopin gnd
M3 Y B net1 gnd nfet w=6u l=0.6u m=1
M4 Y B vdd vdd pfet w=6u l=0.6u m=1
M2 Y A vdd vdd pfet w=6u l=0.6u m=1
M1 net1 A gnd gnd nfet w=6u l=0.6u m=1
.ends

.end
